ADE simulation setup
Run mode: Monte Carlo Sampling
Tests:
  Lab09:MillerOpAmpTB:1: Lab09/MillerOpAmpTB/schematic, simulator spectre
Global variables:
  Ibias = 500u
  Vac = 1
  Vdc = 0
  p5vonly = 0
Monte Carlo Sampling options: mcmethod=all, mcnumpoints=200
